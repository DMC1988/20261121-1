** EtapaVariable **
*
* NI Multisim to SPICE Netlist Export
* Generated by: damca
* Sun, Nov 22, 2026 13:07:39
*

.param Radj=0
.param Rl=27.7

*## Multisim Component Rf1 ##*
rRf1 neg 0 240 vresRf1
.model vresRf1 r(  )

*## Multisim Component Rf ##*
rRf out 6 240 vresRf
.model vresRf r(  )

*## Multisim Component U2 ##*
xU2  8 neg 0  LM337H__VOLTAGE_REGULATOR__1

*## Multisim Component U1 ##*
xU1 in out 6 LM317__VOLTAGE_REGULATOR__1

*## Multisim Component C2 ##*
cC2 0 8 0.001

*## Multisim Component C1 ##*
cC1 3 5 0.001

*## Multisim Component D5 ##*
dD5 5 0 1N4007__DIODE__1

*## Multisim Component D4 ##*
dD4 8 5 1N4007__DIODE__1

*## Multisim Component D2 ##*
dD2 out in 1N4007__DIODE__1

*## Multisim Component C_filtro ##*
cC_filtro in 4 0.0047

*## Multisim Component C_in ##*
cC_in in neg 1e-007

*## Multisim Component C_adj ##*
cC_adj 6 neg 1e-005

*## Multisim Component Cesr ##*
rCesr 4 0 0.05 vresCesr
.model vresCesr r(  )

*## Multisim Component R_adj ##*
rR_adj 6 neg {Radj} vresR_adj
.model vresR_adj r(  )

*## Multisim Component D3 ##*
dD3 6 out 1N4007__DIODE__1

*## Multisim Component C_o ##*
cC_o out neg 1e-006

*## Multisim Component RL ##*
rRL out 0 {Rl} vresRL
.model vresRL r(  )

*## Multisim Component Ri ##*
rRi 1 2 1.37 vresRi
.model vresRi r(  )

*## Multisim Component D1 ##*
xD1 2 3 in 0 GBU6G/VSH__FWB__1

*## Multisim Component V1 ##*
vV1 1 3 dc 0 ac 1 0
+      distof1 0 0
+      distof2 0 0
+      sin(0 {26.13*1.414213562} 50 0 0 0)

.SUBCKT LM337H__VOLTAGE_REGULATOR__1 3 1 2
*      Model Generated by MODPEX     *
*Copyright(c) Symmetry Design Systems*
*         All Rights Reserved        *
*    UNPUBLISHED LICENSED SOFTWARE   *
*   Contains Proprietary Information *
*      Which is The Property of      *
*     SYMMETRY OR ITS LICENSORS      *
*Commercial Use or Resale Restricted *
*   by Symmetry License Agreement    *
* Model generated on Sep  8, 97
* MODEL FORMAT: SPICE3
*Rev. Date: Dec. 20, 1994
*Negative Adjustable Regulator
*External Node Designations
*node 1: VREF (OUTPUT)
*node 2: Ground (Common)
*node 3: Line Voltage
ECCX 131 2 135 2 -1.0
VXX 133 2 DC 0
FSET6 2 135 VSENS2 1
FPP 3 2 VXX 1.0
R_YY 31 2 1e6
R_XX 15 2 1e8
R_ZZ 36 2 1e6
RXX 1 2 1e8
VSENS1 10 1 DC 0
ISET 2 15 DC 1e-3
DON1 15 16 DMOD1
VSENS2 16 19 DC 0
DON2 15 17 DMOD1
EON2 18 2 3 2 -1
FYY 3 2 VSENS1 1
DON3 15 27 DMOD1
VDROP3 28 27 DC 2
EON3 28 2 3 2 -4
ELINE 13 42 66 2 1
FSET2 2 36 VSENS2 1
DSC1 36 35 DMOD1
RCL1 36 37 10
DSC2 37 38 DMOD1
ESCCON 38 39 30 2 1
VSCCON 39 40 DC 0
FSC 19 2 VSCCON 1
FSET3 2 31 VSENS2 1
DOV1 31 32 DMOD1
EOV1 32 2 3 1 -1
DOV2 31 33 DMOD1
ISET4 2 30 DC 1e-3
ELOAD 41 2 77 2 -1
ERIPPLE 42 41 72 2 1
EREF 12 13 19 2 -1
E3 52 2 3 2 1
CBYPS 54 2 0.001
VORB 60 54 DC 0
RB 60 2 1e3
RBR 72 2 1000
CBS2 52 71 1
RSTEP 77 2 1
FRB 2 65 VORB 1
DRB2 65 67 DMOD1
VXRB 67 68 DC -1
EXRB 68 2 1 2 -1
DRB1 65 66 DMOD1
RB1 66 2 1000
.MODEL DMOD1 D
*-- DMOD1 DEFAULT PARAMETERS
*IS=1e-14 RS=0 N=1 TT=0 CJO=0
*VJ=1 M=0.5 EG=1.11 XTI=3 FC=0.5
*KF=0 AF=1 BV=inf IBV=1e-3 TNOM=27
EXX 132 131 3 131 0.000153846
RST6 135 2 10000
RIQX 133 132 RQIX 153846
.MODEL RQIX R TC1=-0
RSET 19 2 RSET 1250
.MODEL RSET R TC1=-6e-05 TC2=-4.47e-07
RS1 10 12 0.003
VDROPX 18 17 1.26
CTRAN 19 2 2.4e-09
HSENSE1 35 2 VSENS1 -12.5
RISC 30 2 RISC 10000
.MODEL RISC R TC1=-0.002
ROV 34 2 25000
VOV 33 34 20
EOV2 2 40 34 2 0.25
FIQD 3 2 VSENS1 2e-06
RY 52 54 4e+06
RA 72 73 2163.76
RYR 71 72 3.16128e+06
CRA 52 73 5.03107e-11
HSTEP 76 2 VSENS1 0.2
CSTEP 76 77 1e-05
.ENDS lm337h

.SUBCKT LM317__VOLTAGE_REGULATOR__1 3 1 2
*      Model Generated by MODPEX     *
*Copyright(c) Symmetry Design Systems*
*         All Rights Reserved        *
*    UNPUBLISHED LICENSED SOFTWARE   *
*   Contains Proprietary Information *
*      Which is The Property of      *
*     SYMMETRY OR ITS LICENSORS      *
*Commercial Use or Resale Restricted *
*   by Symmetry License Agreement    *
* Model generated on Sep  8, 97
* MODEL FORMAT: SPICE3
*Rev. Date: Dec. 20, 1994
*Positive Adjustable Regulator
*External Node Designations
*node 1: VREF (OUTPUT)
*node 2: Ground (Common)
*node 3: Line Voltage
ECCX 131 2 135 2 1.0
VXX 133 2 DC 0
FSET6 2 135 VSENS2 1
FPP 3 2 VXX 1.0
R_YY 31 2 1e6
R_XX 15 2 1e8
R_ZZ 36 2 1e6
R_QQ 65 2 1e8
RXX 1 2 1e8
VSENS1 10 1 DC 0
ISET 2 15 DC 1e-3
DON1 15 16 DMOD1
VSENS2 16 19 DC 0
DON2 15 17 DMOD1
EON2 18 2 3 2 1
FYY 3 2 VSENS1 1
DON3 15 27 DMOD1
VDROP3 28 27 DC 2
EON3 28 2 3 2 4
ELINE 13 42 66 2 1
FSET2 2 36 VSENS2 1
DSC1 36 35 DMOD1
RCL1 36 37 10
DSC2 37 38 DMOD1
ESCCON 38 39 30 2 1
VSCCON 39 40 DC 0
FSC 19 2 VSCCON 1
FSET3 2 31 VSENS2 1
DOV1 31 32 DMOD1
EOV1 32 2 3 1 1
DOV2 31 33 DMOD1
ISET4 2 30 DC 1e-3
ELOAD 41 2 77 2 -1
ERIPPLE 42 41 72 2 1
EREF 12 13 19 2 1
E3 52 2 3 2 1
CBYPS 54 2 0.001
VORB 54 60 DC 0
RB 60 2 1e3
RBR 72 2 1000
CBS2 52 71 1
RSTEP 77 2 1
FRB 2 65 VORB 1
DRB2 65 67 DMOD1
VXRB 67 68 DC -1
EXRB 68 2 1 2 1
DRB1 65 66 DMOD1
RB1 66 2 1000
.MODEL DMOD1 D
*-- DMOD1 DEFAULT PARAMETERS
*IS=1e-14 RS=0 N=1 TT=0 CJO=0
*VJ=1 M=0.5 EG=1.11 XTI=3 FC=0.5
*KF=0 AF=1 BV=inf IBV=1e-3 TNOM=27
EXX 132 131 3 131 0.000375
RST6 135 2 18750
RIQX 133 132 RQIX 375000
.MODEL RQIX R TC1=-0
RSET 19 2 RSET 1250
.MODEL RSET R TC1=0 TC2=0
RS1 10 12 0.001
VDROPX 18 17 2.76
HSENSE1 35 2 VSENS1 4.54545
RISC 30 2 RISC 10000
.MODEL RISC R TC1=-0.003
ROV 34 2 200000
VOV 33 34 100
EOV2 2 40 34 2 0.0409091
FIQD 3 2 VSENS1 0
RY 52 54 8e+06
RA 72 73 9008.11
RYR 71 72 9.999e+06
CRA 52 73 7.95138e-13
HSTEP 76 2 VSENS1 0.01
CSTEP 76 77 5.30516e-06
.ENDS lm317

.MODEL 1N4007__DIODE__1 d (
+IS=3.19863e-08 RS=0.0428545 N=2 EG=0.784214
+XTI=0.504749 BV=1100 IBV=0.0001 CJO=4.67478e-11
+VJ=0.4 M=0.469447 FC=0.5 TT=8.86839e-06
+KF=0 AF=1 )

**********************************
* Model created by               *
*   Uni.Dipl.-Ing. Arpad Buermen *
*   arpad.burmen@ieee.org        *
* Copyright:                     *
*   Thomatronik GmbH, Germany    *
*   info@thomatronik.de          *
**********************************
* November 2000
*   SPICE3
* Nodes 1 and 2: AC input
* Nodes 3 and 4: +/- DC output
.subckt GBU6G/VSH__FWB__1 1 2 3 4
d1 1 3 legd
d2 2 3 legd
d3 4 1 legd
d4 4 2 legd
.model legd d is = 2.1436E-007 n = 2.00256 rs = 0.00511828
+ eg = 1.11 xti = 3 tnom = 27
+ cjo = 3.90022E-010 vj = 1.04449 m = 0.3 fc = 0.5
+ tt = 2.88539E-006 bv = 440 ibv = 0.01 af = 1 kf = 0
.ends

.circuitparams Radj Rl
