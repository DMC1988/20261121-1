** LimiteDeCorriente **
*
* NI Multisim to SPICE Netlist Export
* Generated by: damca
* Mon, Nov 23, 2026 11:31:58
*

.param Radj=1600
.param Rl=9
.param Radji=1

*## Multisim Component R4 ##*
rR4 out 5 680 vresR4
.model vresR4 r(  )

*## Multisim Component R7 ##*
rR7 4 7 100000 vresR7
.model vresR7 r(  )

*## Multisim Component D2 ##*
dD2 5 6 1N4148__SWITCHING_DIODE__1

*## Multisim Component D1 ##*
dD1 7 5 1N4148__SWITCHING_DIODE__1

*## Multisim Component R1 ##*
rR1 in 1 22 vresR1
.model vresR1 r(  )

*## Multisim Component Cl ##*
cCl out 0 0.00047

*## Multisim Component V1 ##*
vV1 in 0 dc 12 ac 0 0
+           distof1 0 0
+           distof2 0 0

*## Multisim Component Rf1 ##*
rRf1 out 7 240 vresRf1
.model vresRf1 r(  )

*## Multisim Component VEE ##*
VEEVEE  VEE 0 dc -1.25

*## Multisim Component R_I ##*
rR_I 3 4 {Radji} vresR_I
.model vresR_I r(  )

*## Multisim Component U2 ##*
xU2 out 4 out VEE 6 U2_OPEN_BAL1 U2_OPEN_COMP LM301A__OPAMP__1

*## Multisim Component R_v ##*
rR_v 7 VEE {Radj} vresR_v
.model vresR_v r(  )

*## Multisim Component R3 ##*
rR3 3 out 0.1 vresR3
.model vresR3 r(  )

*## Multisim Component R2 ##*
rR2 2 out 100 vresR2
.model vresR2 r(  )

*## Multisim Component Q2 ##*
qQ2 in 2 3 2N3055A__BJT_NPN__1

*## Multisim Component Q1 ##*
qQ1 2 1 in TIP42A__BJT_PNP__1

*## Multisim Component U1 ##*
xU1 1 out 7 LM317__VOLTAGE_REGULATOR__1

*## Multisim Component RL ##*
rRL out 0 {Rl} vresRL
.model vresRL r(  )

.MODEL 1N4148__SWITCHING_DIODE__1  D(Is=0.1p Rs=1.6 CJO=2p Tt=12n Bv=100 Ibv=0.1p)

* NODES 1 AND 8 = COMPENSATION PINS
*
.SUBCKT LM301A__OPAMP__1 3 2 7 4 6 1 8
* USE C=30 PF IN MAIN CIRCUIT (CA TO CB).
* INPUT
RC1 7 80 5895
RC2 7 90 5895
Q1 80 2 10 QM1
Q2 90 3 11 QM2
C1 80 90 5.46e-12
RE1 10 12 2438
RE2 11 12 2438
IEE 12 4 1.506e-5
RE 12 0 13280000
CE 12 0 1.579E-12
* INTERMEDIATE
GCM 0 8 12 0 2.689e-9
GA 8 0 80 90 1.696E-04
R2 8 0 100000
* EXTERNAL COMP CAP USED FOR C2 (SEE NOTE ABOVE).
GB 1 0 8 0 140.1
* OUTPUT
RO1 1 6 33.33
RO2 1 0 66.67
RC 17 0 4.758e-5
GC 0 17 6 0 21020
D1 1 17 DM1
D2 17 1 DM1
D3 6 13 DM2
D4 14 6 DM2
VC 7 13 1.808
VE 14 4 1.808
IP 7 4 0.001785
DSUB 4 7 DM2
* MODELS
.MODEL QM1 NPN(IS=8e-16 BF=104.9)
.MODEL QM2 NPN(IS=8.647E-16 BF=109.5)
.MODEL DM1 D(IS=3.337E-15)
.MODEL DM2 D(IS=8e-16)
.ENDS LM301A
*

.MODEL 2N3055A__BJT_NPN__1  npn
+IS=3.41639e-13 BF=405.26 NF=1.03507 VAF=120.176
+IKF=10 ISE=8.44498e-12 NE=3.47601 BR=0.1
+NR=1.04536 VAR=1.10398 IKR=2.5029 ISC=5.50017e-13
+NC=3.93748 RB=1.80955 IRB=6.50293 RBM=1.80955
+RE=0.0001 RC=0.13777 XTB=0.1 XTI=1
+EG=1.05 CJE=6.36056e-10 VJE=0.4 MJE=0.479146
+TF=7.91835e-08 XTF=463.212 VTF=62107.5 ITF=1000
+CJC=2.70642e-10 VJC=0.95 MJC=0.406578 XCJC=0.128859
+FC=0.8 CJS=0 VJS=0.75 MJS=0.5
+TR=8.186e-05 PTF=0 KF=0 AF=1

.MODEL TIP42A__BJT_PNP__1 pnp
+IS=1.85462e-10 BF=127.718 NF=1.18032 VAF=21.7214
+IKF=1.65701 ISE=7.76909e-12 NE=3.33995 BR=3.4294
+NR=1.24514 VAR=3.82812 IKR=8.39402 ISC=4.75e-13
+NC=3.96875 RB=4.12543 IRB=0.1 RBM=0.1
+RE=0.000884049 RC=0.110161 XTB=2.15329 XTI=1
+EG=1.05 CJE=2.00775e-10 VJE=0.4 MJE=0.277234
+TF=1e-08 XTF=4.33068 VTF=6.65977 ITF=0.001
+CJC=1.07844e-10 VJC=0.709164 MJC=0.23 XCJC=0.803034
+FC=0.8 CJS=0 VJS=0.75 MJS=0.5
+TR=1e-07 PTF=0 KF=0 AF=1

.SUBCKT LM317__VOLTAGE_REGULATOR__1 3 1 2
*      Model Generated by MODPEX     *
*Copyright(c) Symmetry Design Systems*
*         All Rights Reserved        *
*    UNPUBLISHED LICENSED SOFTWARE   *
*   Contains Proprietary Information *
*      Which is The Property of      *
*     SYMMETRY OR ITS LICENSORS      *
*Commercial Use or Resale Restricted *
*   by Symmetry License Agreement    *
* Model generated on Sep  8, 97
* MODEL FORMAT: SPICE3
*Rev. Date: Dec. 20, 1994
*Positive Adjustable Regulator
*External Node Designations
*node 1: VREF (OUTPUT)
*node 2: Ground (Common)
*node 3: Line Voltage
ECCX 131 2 135 2 1.0
VXX 133 2 DC 0
FSET6 2 135 VSENS2 1
FPP 3 2 VXX 1.0
R_YY 31 2 1e6
R_XX 15 2 1e8
R_ZZ 36 2 1e6
R_QQ 65 2 1e8
RXX 1 2 1e8
VSENS1 10 1 DC 0
ISET 2 15 DC 1e-3
DON1 15 16 DMOD1
VSENS2 16 19 DC 0
DON2 15 17 DMOD1
EON2 18 2 3 2 1
FYY 3 2 VSENS1 1
DON3 15 27 DMOD1
VDROP3 28 27 DC 2
EON3 28 2 3 2 4
ELINE 13 42 66 2 1
FSET2 2 36 VSENS2 1
DSC1 36 35 DMOD1
RCL1 36 37 10
DSC2 37 38 DMOD1
ESCCON 38 39 30 2 1
VSCCON 39 40 DC 0
FSC 19 2 VSCCON 1
FSET3 2 31 VSENS2 1
DOV1 31 32 DMOD1
EOV1 32 2 3 1 1
DOV2 31 33 DMOD1
ISET4 2 30 DC 1e-3
ELOAD 41 2 77 2 -1
ERIPPLE 42 41 72 2 1
EREF 12 13 19 2 1
E3 52 2 3 2 1
CBYPS 54 2 0.001
VORB 54 60 DC 0
RB 60 2 1e3
RBR 72 2 1000
CBS2 52 71 1
RSTEP 77 2 1
FRB 2 65 VORB 1
DRB2 65 67 DMOD1
VXRB 67 68 DC -1
EXRB 68 2 1 2 1
DRB1 65 66 DMOD1
RB1 66 2 1000
.MODEL DMOD1 D
*-- DMOD1 DEFAULT PARAMETERS
*IS=1e-14 RS=0 N=1 TT=0 CJO=0
*VJ=1 M=0.5 EG=1.11 XTI=3 FC=0.5
*KF=0 AF=1 BV=inf IBV=1e-3 TNOM=27
EXX 132 131 3 131 0.000375
RST6 135 2 18750
RIQX 133 132 RQIX 375000
.MODEL RQIX R TC1=-0
RSET 19 2 RSET 1250
.MODEL RSET R TC1=0 TC2=0
RS1 10 12 0.001
VDROPX 18 17 2.76
HSENSE1 35 2 VSENS1 4.54545
RISC 30 2 RISC 10000
.MODEL RISC R TC1=-0.003
ROV 34 2 200000
VOV 33 34 100
EOV2 2 40 34 2 0.0409091
FIQD 3 2 VSENS1 0
RY 52 54 8e+06
RA 72 73 9008.11
RYR 71 72 9.999e+06
CRA 52 73 7.95138e-13
HSTEP 76 2 VSENS1 0.01
CSTEP 76 77 5.30516e-06
.ENDS lm317

.circuitparams Radj Rl Radji
